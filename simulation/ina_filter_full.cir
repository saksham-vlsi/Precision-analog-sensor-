* ============================================================================
* Precision Analog Sensor Front-End : 3-op-amp INA (G1=20.05) + diff amp (G2=5)
*                                     + 2nd-order Sallen-Key Butterworth LPF
* Single supply 3.3 V, mid-rail reference 1.65 V.  Open in LTspice: File > Open.
* ============================================================================
.include opamp_rr.lib

.param Vdd=3.3
.param R1v=10k Rgv=1.05k R2v=20k R3v=100k
.param Rfv=11.3k C2v=10n C1v=20n

* ---- supply & mid-rail reference (divider + buffer A4) ---------------------
Vdd  vdd 0 {Vdd}
Rd1  vdd vrefin 10k
Rd2  vrefin 0   10k
Cd1  vrefin 0   1u
XA4  vrefin vref vref vdd 0 OPA_RR
Cref vref 0 100n

* ---- bridge sensor model: common-mode 1.65 V, differential 'sig' -----------
* sig: AC=1 for .ac, +/-10 mV square wave for .tran, DC value for .op
Vsig  sig 0 DC 0 AC 1 PULSE(-10m 10m 2m 1u 1u 8m 20m)
Vcm   vcmn 0 {Vdd/2}
Ep    ipsrc vcmn sig 0  0.5
En    insrc vcmn sig 0 -0.5
Rsp   ipsrc inpx 500
Rsn   insrc innx 500

* ---- input protection / RFI filter -----------------------------------------
Rfp   inpx inp 1k
Rfn   innx inn 1k
Cdif  inp inn 10n
Ccp   inp 0 1n
Ccn   inn 0 1n

* ---- INA stage 1 (A1, A2) ---------------------------------------------------
XA1   inp a1n o1 vdd 0 OPA_RR
XA2   inn a2n o2 vdd 0 OPA_RR
R1a   o1 a1n {R1v}
R1b   o2 a2n {R1v}
Rg    a1n a2n {Rgv}

* ---- INA stage 2: difference amplifier (A3), gain R3/R2, referenced to Vref -
XA3   a3p a3n o3 vdd 0 OPA_RR
R2p   o1  a3p {R2v}
R3p   a3p vref {R3v}
R2n   o2  a3n {R2v}
R3n   o3  a3n {R3v}

* ---- Sallen-Key low-pass (A5), unity gain -----------------------------------
Rs1   o3  skx {Rfv}
Rs2   skx sky {Rfv}
Cs1   skx o5  {C1v}
Cs2   sky 0   {C2v}
XA5   sky o5 o5 vdd 0 OPA_RR

* ---- ADC input network (STM32 PA0) ------------------------------------------
Radc  o5 adc 100
Cadc  adc 0 10n

* ---- analyses ---------------------------------------------------------------
.op
.ac dec 100 1 1meg
.tran 0 20m 0 5u
.noise V(adc) Vsig dec 50 1 100k

.meas AC gain_1Hz  FIND mag(V(adc)) AT 1
.meas AC f_3db     WHEN mag(V(adc))=gain_1Hz/1.41421 FALL=1
.meas AC gain_at_10k FIND mag(V(adc)) AT 10k
.meas TRAN vmax    MAX V(adc)
.meas TRAN vmin    MIN V(adc)
.meas TRAN vref_dc AVG V(vref)
.end
